.title KiCad schematic
.ac dec 200 100 100k
L1 Net-_L1-Pad1_ /pf 35.4249
V1 Net-_L1-Pad1_ GND DC 1 AC 1
G1 /pf /pb /u GND 0.000254469
R1 /pb Net-_L2-Pad1_ 10Meg
L2 Net-_L2-Pad1_ Net-_C1-Pad1_ 100
C1 Net-_C1-Pad1_ GND 7.16145p
R4 Net-_C1-Pad1_ GND 1T
C2 /u GND 50u
L3 /u /mech_sense 4u
R3 /u GND 1
R2 /mech_sense GND 1u
R5 /out GND 500Meg
CE0 /ce0 GND 112.603p
E1 /ce0 /out /mech_sense GND 40000000
G3 GND /u /ce0 GND -0.00112603
G2 GND /u /pf /pb 0.000254469
.end
