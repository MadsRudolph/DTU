.title KiCad schematic
.ac dec 200 1 10k
R2 /u GND 0.5
L2 /u GND 1m
C1 /u GND 10m
R1 /vin /n1 5
L1 /n1 Net-_E1-N+_ 0.3m
E1 Net-_E1-N+_ GND /u GND 2.1
G1 GND /u /vin /n1 0.42
V1 /vin GND DC 1 AC 1
.end
