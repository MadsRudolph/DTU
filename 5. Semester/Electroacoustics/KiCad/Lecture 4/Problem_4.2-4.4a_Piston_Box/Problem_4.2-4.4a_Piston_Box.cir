.title KiCad schematic
.ac dec 500 5 5k
.options abstol=1e-14 vntol=1e-12
G1 GND /p /u GND 0.01
R1 /p Net-_C1-Pad1_ 40592
R2 Net-_C1-Pad1_ /pb 17901.1
V2 /fa GND DC 0 AC 1
E1 GND Net-_E1-N-_ GND /pi 0.01
R6 /fa /fb 1u
L4 /fb Net-_E1-N-_ 0.02
L5 /pi /pb2 5.65101
R8 Net-_C3-Pad1_ /pb2 17901.1
C3 Net-_C3-Pad1_ /pb2 7.63946n
L6 /pb2 /pc2 2.36
C4 /pc2 GND 286.458n
R9 /pc2 GND 1T
R7 /pi Net-_C3-Pad1_ 40592
I1 GND /u DC 0 AC 1
C5 /u GND 0.02
G3 GND /pi /fa /fb 10000
G2 /u GND /p GND 0.01
R10 /u GND 1T
L1 /p /pb 5.65101
L3 /pb /pc 2.36
C1 Net-_C1-Pad1_ /pb 7.63946n
R3 /pc GND 1T
C2 /pc GND 286.458n
.end
