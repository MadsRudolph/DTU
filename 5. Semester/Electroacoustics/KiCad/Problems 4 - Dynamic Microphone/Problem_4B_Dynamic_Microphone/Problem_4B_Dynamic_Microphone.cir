.title KiCad schematic
.ac dec 200 10 100k
L1 Net-_L1-Pad1_ /pf 25.1
G2 GND /u /pf /pb 0.000506707
G1 /pf /pb /u GND 0.000506707
V1 Net-_L1-Pad1_ GND DC 1 AC 1
R1 /pb Net-_C1-Pad1_ 20Meg
C1 Net-_C1-Pad1_ GND 35.8p
R3 Net-_C1-Pad1_ GND 1T
G3 /u GND /out GND 0.000425532
R5 Net-_E1-N+_ /out 200
R6 /out GND 47000
R4 /u GND 1
E1 Net-_E1-N+_ GND /u GND 20
L2 /u GND 0.00021
C2 /u GND 0.0002
.end
