* ============================================================
* 34655 Two-Stage CMOS Operational Amplifier — OPEN LOOP
* Course 34655 - Integrated Analog Electronics 2
*
* Topology: PMOS diff pair, NMOS mirror load, NMOS CS 2nd stage
* Process:  0.18 um CMOS (Carusone Table 1.5)
* VDD = 1.8 V, Ibias = 20 uA
*
* This netlist measures open-loop gain, GBW, and phase margin.
* ============================================================

* ============================================
* SUPPLY
* ============================================
Vdd vdd 0 DC 1.8

* ============================================
* INPUT SIGNAL (open loop — AC stimulus on non-inv input)
* ============================================
* DC bias at mid-rail for the input, AC = 1 for Bode analysis
Vin vin 0 DC 0.9 AC 1

* ============================================
* BIAS CIRCUIT
* ============================================
Ibias n_bias 0 DC 20u
MQ8 n_bias n_bias vdd vdd PMOS_018 W=14u L=1u

* ============================================
* FIRST STAGE: PMOS Differential Pair
* ============================================
MQ5 n_tail n_bias vdd vdd PMOS_018 W=17u L=1u

MQ1 n_d1 n_inv n_tail vdd PMOS_018 W=24u L=1u
MQ2 n_d2 vin   n_tail vdd PMOS_018 W=24u L=1u

MQ3 n_d1 n_d1 0 0 NMOS_018 W=6.2u L=1u
MQ4 n_d2 n_d1 0 0 NMOS_018 W=6.2u L=1u

* ============================================
* SECOND STAGE: NMOS Common-Source
* ============================================
MQ6 vout n_bias vdd vdd PMOS_018 W=43u L=1u
MQ7 vout n_d2  0   0   NMOS_018 W=31u L=1u

* ============================================
* MILLER COMPENSATION (Rc + Cc)
* ============================================
Rc n_d2 n_comp 995
Cc n_comp vout 0.8p

* ============================================
* OPEN-LOOP LOAD
* ============================================
* Inverting input tied to DC bias (no feedback)
Vbias_inv n_inv 0 DC 0.9
CL vout 0 1.5p

* ============================================
* TRANSISTOR MODELS (0.18 um CMOS, Level 1)
* ============================================
.model NMOS_018 nmos (level=1 kp=270u vto=0.5 lambda=0.08 gamma=0.4 phi=0.65)
.model PMOS_018 pmos (level=1 kp=70u vto=-0.45 lambda=0.08 gamma=0.4 phi=0.65)

* ============================================
* SIMULATION: AC Analysis (Bode plot)
* ============================================
.ac dec 200 1 10G

* ============================================
* MEASUREMENTS
* ============================================
* DC gain (magnitude at 1 Hz ≈ DC)
.meas AC dc_gain find vdb(vout) at=1
* Unity-gain frequency (0 dB crossing)
.meas AC ugf when vdb(vout)=0
* Phase at unity gain (for phase margin = 180 + phase)
.meas AC phase_at_ugf find vp(vout) when vdb(vout)=0

.end
